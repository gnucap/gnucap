Test modelgen internal node re-expansion after a change
******************************************************************
.load ./c_debug.so
.options trace
MN1 1 1 0 0 NMOS L=10U W=50.0U AD=100P AS=100P PD=40U PS=40U
***************************************************************
.MODEL  NMOS   NMOS
+           LEVEL = 4.00000E+000
+             TOX = 3.00000E-002
+             VDD = 5.00000E+000
+            TEMP = 2.70000E+001
+              DL = 7.97991E-001
+              DW = 4.77402E-001
+             VFB = -1.0087E+000
+             PHI = 7.96434E-001
+              K1 = 1.31191E+000
+              K2 = 1.46640E-001
+             ETA = -1.0027E-003
+             MUZ = 5.34334E+002
+              U0 = 4.38497E-002
+              U1 = -5.7332E-002
+            LETA = -9.4847E-003
+            WETA = 1.47316E-002
+             LU0 = 6.38105E-002
+             WU0 = -6.1053E-002
+             LU1 = 1.01174E+000
+             WU1 = 1.62706E-002
+              N0 = 1.55
+              NB = 0.09
+            CGDO = 2.70000E-010
+            CGSO = 2.70000E-010
+            CGBO = 1.40000E-010
+           XPART = 1.2
+             RSH = 35.0
+              CJ = 2.75E-4
+             CJSW = 1.90E-10
+             JS = 1.0E-8
+              PB = 0.7
+             PBSW = 0.8
+              MJ = 0.5
+             MJSW = 0.33
+             WDF = 0.0
*****                                        *****
.DC
.status notime
.PRINT DC V(nodes)
.DC
.status notime
.portdump

v2 1 0 0
.PRINT DC V(nodes)
.DC
.status notime
.portdump

.options norstray
.DC
.status notime
.portdump

* BUG: !is_first_expand and rstray change hits assertion
* delete v2
* .DC
* .status notime
