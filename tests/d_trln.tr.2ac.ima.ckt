#Transmission lines

.width out=200
.gen freq=10meg

V1 1 0 gen(1)

# matched
R1s 1 11 50
T1 11 0 13 0 z=50 f=10meg nl=.01
T1 13 0 12 0 z=50 f=10meg nl=.24
R1l 12 0 50

# open stub
R2s 1 21 50
T2 21 0 23 0 z=50 f=10meg nl=.01
T2 23 0 22 0 z=50 f=10meg nl=.24
R2l 22 0 1e99

# shorted stub
R3s 1 31 50
T3 31 0 33 0 z=50 f=10meg nl=.01
T3 33 0 32 0 z=50 f=10meg nl=.24
R3l 32 0 .001

# lo-z load
R4s 1 41 50
T4 41 0 43 0 z=50 f=10meg nl=.01
T4 43 0 42 0 z=50 f=10meg nl=.24
R4l 42 0 25

# hi-z load
R5s 1 51 50
T5 51 0 53 0 z=50 f=10meg nl=.01
T5 53 0 52 0 z=50 f=10meg nl=.24
R5l 52 0 100

.list
.print tran v nodes

# nominal-z drive
.tran 100n trace all basic

# very lo-z drive
.modify R?s=.1
.print tran v nodes
.tr 0 300n trace all basic

# slightly lo-z drive
.modify R?s=25
.print tran v nodes
.tr 0 300n trace all basic

# hi-z drive
.modify R?s=100
.print tran v nodes
.tr 100n trace all basic
.tr 600n 5n trace all basic

.stat notime
.end
