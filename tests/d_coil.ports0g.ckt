Mutual inductance portdump, 2a only, with extra ground
.load ./c_debug.so
.param L1 = .56
.param L2 = .79
.param L3 = .58
.param K12 = .75
.param K23 = .54
.param K13 = .66
.param Rsource = 22
.param Rload1 = 75
.param Rload2 = 90

* using 'k' pseudo element
.subckt trans3a (a1 a2 b1 b2 c1 c2)
k1 (l2 l1) {K12}
k2 (l3 l2) {K23}
k3 (l1 l3) {K13}
l1 (a1 a2) {L1}
l2 (b1 b2) {L2}
l3 (c1 c2) {L3}
.ends

va1 (a1 g)           pulse(0 1 .002 .002 .002 .002 .01) ac 1
ra1 (a2 a1)          {Rsource}
xa1 (g a2 g a3 g a4) trans3a L1=L1 L2=L2 L3=L3 K12=K12 K23=K23 K13=K13
ra2 (g a3)           {Rload1}
ra3 (g a4)           {Rload2}
rg 0 g .01

.options nopage
.width out=200
.print ac vm(a2) vm(a3) vm(a4) vm(b2) vm(b3) vm(b4) vm(c2) vm(c3) vm(c4) vm(d2) vm(d3) vm(d4)
.ac dec 2 .1 1k
.portdump
.print ac vp(a2) vp(a3) vp(a4) vp(b2) vp(b3) vp(b4) vp(c2) vp(c3) vp(c4) vp(d2) vp(d3) vp(d4)
.ac dec 2 .1 1k
.print tran  v(a2) v(a3) v(a4) v(b2) v(b3) v(b4) v(c2) v(c3) v(c4) v(d2) v(d3) v(d4)
.tran .001 .01 0 .0001
.status notime
.portdump
.end
